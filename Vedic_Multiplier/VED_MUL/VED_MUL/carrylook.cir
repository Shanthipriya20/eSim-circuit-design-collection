* C:\Users\Shanthipriya\Desktop\madeeasy\FOSSEE\eSim\library\SubcircuitLibrary\carrylook\carrylook.cir

* EESchema Netlist Version 1.1 (Spice format) creation date: 12/01/24 01:50:30

* To exclude a component from the Spice Netlist add [Spice_Netlist_Enabled] user FIELD set to: N
* To reorder the component spice node sequence add [Spice_Node_Sequence] user FIELD and define sequence: 2,1,0

* Sheet Name: /
U2  Net-_U1-Pad2_ Net-_U1-Pad1_ Net-_U10-Pad1_ d_and
U6  Net-_U11-Pad3_ Net-_U4-Pad3_ Net-_U10-Pad2_ d_and
U4  Net-_U1-Pad1_ Net-_U1-Pad2_ Net-_U4-Pad3_ d_xor
U7  Net-_U11-Pad3_ Net-_U4-Pad3_ Net-_U1-Pad7_ d_xor
U10  Net-_U10-Pad1_ Net-_U10-Pad2_ Net-_U1-Pad8_ d_or
U3  Net-_U1-Pad4_ Net-_U1-Pad3_ Net-_U11-Pad2_ d_and
U8  Net-_U1-Pad5_ Net-_U5-Pad3_ Net-_U11-Pad1_ d_and
U5  Net-_U1-Pad4_ Net-_U1-Pad3_ Net-_U5-Pad3_ d_xor
U9  Net-_U1-Pad5_ Net-_U5-Pad3_ Net-_U1-Pad6_ d_xor
U11  Net-_U11-Pad1_ Net-_U11-Pad2_ Net-_U11-Pad3_ d_or
U1  Net-_U1-Pad1_ Net-_U1-Pad2_ Net-_U1-Pad3_ Net-_U1-Pad4_ Net-_U1-Pad5_ Net-_U1-Pad6_ Net-_U1-Pad7_ Net-_U1-Pad8_ PORT

.end
